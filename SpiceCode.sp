* Danial Yaghooti - Mohammad Jafari Naeemi

* 4-bit Shifregister TEST

.model NMOS nmos level=1 VTO=0.7 KP=120u GAMMA=0 PHI=0.7 NSUB=1E17
.model PMOS pmos level=1 VTO=-0.8 KP=40u GAMMA=0 PHI=0.7 NSUB=1E17

V_VDD VDD 0 DC 5
V_GND GND 0 DC 0

VCLK CLK 0 PULSE(0 5 0 0.1n 0.1n 10n 40n)

VIN IN 0 PWL(0n 5V 15n 5V 20n 0V 40n 0V
+ 40.1n 5V 55n 5V 55.1n 0V 80n 0V
+ 80.1n 5V 95n 5V 95.1n 0V 100n 0V)

Cpar1 OUT_4 0 C=28.928f
Cpar2 PRIMARY_OUT4 0 C=48.6165f
Cpar3 INV_8 0 C=19.0125f
Cpar4 P_OUT4 0 C=19.0125f
Cpar5 INV_7 0 C=19.0125f
Cpar6 N_OUT4 0 C=19.0125f
Cpar7 OUT_3 0 C=34.236f
Cpar8 INV_6 0 C=19.0125f
Cpar9 P_OUT3 0 C=19.0125f
Cpar10 PRIMARY_OUT3 0 C=48.6165f
Cpar11 OUT_2 0 C=34.6485f
Cpar12 INV_5 0 C=19.0125f
Cpar13 N_OUT3 0 C=19.0125f
Cpar14 INV_4 0 C=19.0125f
Cpar15 P_OUT2 0 C=19.0125f
Cpar16 PRIMARY_OUT2 0 C=48.6165f
Cpar17 INV_3 0 C=19.0125f
Cpar18 N_OUT2 0 C=19.0125f
Cpar19 OUT_1 0 C=33.8235f
Cpar20 PRIMARY_OUT 0 C=48.504f
Cpar21 P_OUT1 0 C=19.0125f
Cpar22 VDD 0 C=266.1325f
Cpar23 GND 0 C=196.2175f
Cpar24 IN 0 C=5.608f
Cpar25 INV_1 0 C=19.0125f
Cpar26 N_OUT1 0 C=19.0125f
Cpar27 CLK 0 C=39.9875f
Cpar28 INV_2 0 C=19.0125f

M_N24 OUT_4 INV_8 GND GND NMOS L=2u W=6u AD=36p PD=24u AS=36p PS=24u
* M_N24 DRAIN GATE SOURCE BULK (670.5 -172 672.5 -166)
M_P24 OUT_4 INV_8 VDD VDD PMOS L=2u W=6u AD=36p PD=24u AS=36p PS=24u
* M_P24 DRAIN GATE SOURCE BULK (670.5 -153 672.5 -147)
M_N23 INV_8 P_OUT4 GND GND NMOS L=2u W=6u AD=36p PD=24u AS=36p PS=24u
* M_N23 DRAIN GATE SOURCE BULK (653.5 -172 655.5 -166)
M_N22 P_OUT4 CLK OUT_4 GND NMOS L=2u W=6u AD=36p PD=24u AS=36p PS=24u
* M_N22 DRAIN GATE SOURCE BULK (636.5 -172 638.5 -166)
M_N21 PRIMARY_OUT4 INV_7 GND GND NMOS L=2u W=6u AD=36p PD=24u AS=36p PS=24u
* M_N21 DRAIN GATE SOURCE BULK (602.5 -172 604.5 -166)
M_N20 INV_7 N_OUT4 GND GND NMOS L=2u W=6u AD=36p PD=24u AS=36p PS=24u
* M_N20 DRAIN GATE SOURCE BULK (585.5 -172 587.5 -166)
M_N19 N_OUT4 CLK OUT_3 GND NMOS L=2u W=6u AD=36p PD=24u AS=36p PS=24u
* M_N19 DRAIN GATE SOURCE BULK (568.5 -172 570.5 -166)
M_P23 INV_8 P_OUT4 VDD VDD PMOS L=2u W=6u AD=36p PD=24u AS=36p PS=24u
* M_P23 DRAIN GATE SOURCE BULK (653.5 -153 655.5 -147)
M_P22 P_OUT4 CLK PRIMARY_OUT4 VDD PMOS L=2u W=6u AD=36p PD=24u AS=36p PS=24u
* M_P22 DRAIN GATE SOURCE BULK (636.5 -153 638.5 -147)
M_P21 PRIMARY_OUT4 INV_7 VDD VDD PMOS L=2u W=6u AD=36p PD=24u AS=36p PS=24u
* M_P21 DRAIN GATE SOURCE BULK (602.5 -153 604.5 -147)
M_P20 INV_7 N_OUT4 VDD VDD PMOS L=2u W=6u AD=36p PD=24u AS=36p PS=24u
* M_P20 DRAIN GATE SOURCE BULK (585.5 -153 587.5 -147)
M_P19 N_OUT4 CLK PRIMARY_OUT4 VDD PMOS L=2u W=6u AD=36p PD=24u AS=36p PS=24u
* M_P19 DRAIN GATE SOURCE BULK (568.5 -153 570.5 -147)
M_N18 OUT_3 INV_6 GND GND NMOS L=2u W=6u AD=36p PD=24u AS=36p PS=24u
* M_N18 DRAIN GATE SOURCE BULK (534.5 -172 536.5 -166)
M_N17 INV_6 P_OUT3 GND GND NMOS L=2u W=6u AD=36p PD=24u AS=36p PS=24u
* M_N17 DRAIN GATE SOURCE BULK (517.5 -172 519.5 -166)
M_N16 P_OUT3 CLK OUT_3 GND NMOS L=2u W=6u AD=36p PD=24u AS=36p PS=24u
* M_N16 DRAIN GATE SOURCE BULK (500.5 -172 502.5 -166)
M_N15 PRIMARY_OUT3 INV_5 GND GND NMOS L=2u W=6u AD=36p PD=24u AS=36p PS=24u
* M_N15 DRAIN GATE SOURCE BULK (466.5 -172 468.5 -166)
M_P18 OUT_3 INV_6 VDD VDD PMOS L=2u W=6u AD=36p PD=24u AS=36p PS=24u
* M_P18 DRAIN GATE SOURCE BULK (534.5 -153 536.5 -147)
M_P17 INV_6 P_OUT3 VDD VDD PMOS L=2u W=6u AD=36p PD=24u AS=36p PS=24u
* M_P17 DRAIN GATE SOURCE BULK (517.5 -153 519.5 -147)
M_P16 P_OUT3 CLK PRIMARY_OUT3 VDD PMOS L=2u W=6u AD=36p PD=24u AS=36p PS=24u
* M_P16 DRAIN GATE SOURCE BULK (500.5 -153 502.5 -147)
M_P15 PRIMARY_OUT3 INV_5 VDD VDD PMOS L=2u W=6u AD=36p PD=24u AS=36p PS=24u
* M_P15 DRAIN GATE SOURCE BULK (466.5 -153 468.5 -147)
M_N14 INV_5 N_OUT3 GND GND NMOS L=2u W=6u AD=36p PD=24u AS=36p PS=24u
* M_N14 DRAIN GATE SOURCE BULK (449.5 -172 451.5 -166)
M_N13 N_OUT3 CLK OUT_2 GND NMOS L=2u W=6u AD=36p PD=24u AS=36p PS=24u
* M_N13 DRAIN GATE SOURCE BULK (432.5 -172 434.5 -166)
M_N12 OUT_2 INV_4 GND GND NMOS L=2u W=6u AD=36p PD=24u AS=36p PS=24u
* M_N12 DRAIN GATE SOURCE BULK (397.5 -172 399.5 -166)
M_N11 INV_4 P_OUT2 GND GND NMOS L=2u W=6u AD=36p PD=24u AS=36p PS=24u
* M_N11 DRAIN GATE SOURCE BULK (380.5 -172 382.5 -166)
M_N10 P_OUT2 CLK OUT_2 GND NMOS L=2u W=6u AD=36p PD=24u AS=36p PS=24u
* M_N10 DRAIN GATE SOURCE BULK (363.5 -172 365.5 -166)
M_P14 INV_5 N_OUT3 VDD VDD PMOS L=2u W=6u AD=36p PD=24u AS=36p PS=24u
* M_P14 DRAIN GATE SOURCE BULK (449.5 -153 451.5 -147)
M_P13 N_OUT3 CLK PRIMARY_OUT3 VDD PMOS L=2u W=6u AD=36p PD=24u AS=36p PS=24u
* M_P13 DRAIN GATE SOURCE BULK (432.5 -153 434.5 -147)
M_P12 OUT_2 INV_4 VDD VDD PMOS L=2u W=6u AD=36p PD=24u AS=36p PS=24u
* M_P12 DRAIN GATE SOURCE BULK (397.5 -153 399.5 -147)
M_P11 INV_4 P_OUT2 VDD VDD PMOS L=2u W=6u AD=36p PD=24u AS=36p PS=24u
* M_P11 DRAIN GATE SOURCE BULK (380.5 -153 382.5 -147)
M_P10 P_OUT2 CLK PRIMARY_OUT2 VDD PMOS L=2u W=6u AD=36p PD=24u AS=36p PS=24u
* M_P10 DRAIN GATE SOURCE BULK (363.5 -153 365.5 -147)
M_N9 PRIMARY_OUT2 INV_3 GND GND NMOS L=2u W=6u AD=36p PD=24u AS=36p PS=24u
* M_N9 DRAIN GATE SOURCE BULK (329.5 -172 331.5 -166)
M_N8 INV_3 N_OUT2 GND GND NMOS L=2u W=6u AD=36p PD=24u AS=36p PS=24u
* M_N8 DRAIN GATE SOURCE BULK (312.5 -172 314.5 -166)
M_N7 N_OUT2 CLK OUT_1 GND NMOS L=2u W=6u AD=36p PD=24u AS=36p PS=24u
* M_N7 DRAIN GATE SOURCE BULK (295.5 -172 297.5 -166)
M_N6 OUT_1 INV_2 GND GND NMOS L=2u W=6u AD=36p PD=24u AS=36p PS=24u
* M_N6 DRAIN GATE SOURCE BULK (271.5 -172 273.5 -166)
M_P9 PRIMARY_OUT2 INV_3 VDD VDD PMOS L=2u W=6u AD=36p PD=24u AS=36p PS=24u
* M_P9 DRAIN GATE SOURCE BULK (329.5 -153 331.5 -147)
M_P8 INV_3 N_OUT2 VDD VDD PMOS L=2u W=6u AD=36p PD=24u AS=36p PS=24u
* M_P8 DRAIN GATE SOURCE BULK (312.5 -153 314.5 -147)
M_P7 N_OUT2 CLK PRIMARY_OUT2 VDD PMOS L=2u W=6u AD=36p PD=24u AS=36p PS=24u
* M_P7 DRAIN GATE SOURCE BULK (295.5 -153 297.5 -147)
M_P6 OUT_1 INV_2 VDD VDD PMOS L=2u W=6u AD=36p PD=24u AS=36p PS=24u
* M_P6 DRAIN GATE SOURCE BULK (271.5 -153 273.5 -147)
M_N5 INV_2 P_OUT1 GND GND NMOS L=2u W=6u AD=36p PD=24u AS=36p PS=24u
* M_N5 DRAIN GATE SOURCE BULK (254.5 -172 256.5 -166)
M_N4 P_OUT1 CLK OUT_1 GND NMOS L=2u W=6u AD=36p PD=24u AS=36p PS=24u
* M_N4 DRAIN GATE SOURCE BULK (237.5 -172 239.5 -166)
M_N3 PRIMARY_OUT INV_1 GND GND NMOS L=2u W=6u AD=36p PD=24u AS=36p PS=24u
* M_N3 DRAIN GATE SOURCE BULK (205 -172 207 -166)
M_N2 INV_1 N_OUT1 GND GND NMOS L=2u W=6u AD=36p PD=24u AS=36p PS=24u
* M_N2 DRAIN GATE SOURCE BULK (188 -172 190 -166)
M_N1 N_OUT1 CLK IN GND NMOS L=2u W=6u AD=36p PD=24u AS=36p PS=24u
* M_N1 DRAIN GATE SOURCE BULK (171 -172 173 -166)
M_P5 INV_2 P_OUT1 VDD VDD PMOS L=2u W=6u AD=36p PD=24u AS=36p PS=24u
* M_P5 DRAIN GATE SOURCE BULK (254.5 -153 256.5 -147)
M_P4 P_OUT1 CLK PRIMARY_OUT VDD PMOS L=2u W=6u AD=36p PD=24u AS=36p PS=24u
* M_P4 DRAIN GATE SOURCE BULK (237.5 -153 239.5 -147)
M_P3 PRIMARY_OUT INV_1 VDD VDD PMOS L=2u W=6u AD=36p PD=24u AS=36p PS=24u
* M_P3 DRAIN GATE SOURCE BULK (205 -153 207 -147)
M_P2 INV_1 N_OUT1 VDD VDD PMOS L=2u W=6u AD=36p PD=24u AS=36p PS=24u
* M_P2 DRAIN GATE SOURCE BULK (188 -153 190 -147)
M_P1 N_OUT1 CLK PRIMARY_OUT VDD PMOS L=2u W=6u AD=36p PD=24u AS=36p PS=24u
* M_P1 DRAIN GATE SOURCE BULK (171 -153 173 -147)

.tran 0.1n 160n
.option post probe
.probe tran V(CLK) V(IN) V(OUT_1) V(OUT_2) V(OUT_3) V(OUT_4)
.END
